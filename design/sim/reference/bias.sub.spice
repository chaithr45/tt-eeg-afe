* Bias generator: subthreshold beta-multiplier (constant-gm), start-up, VREF
* ports: vdd vss vbp vref
.subckt bias vdd vss vbp vref
+ WB=7 LB=1 MB=2 K=4 RSL=16 WRS=0.35
* PMOS mirror (unit cells identical to the OTA current sources: W=4 L=2)
XM11 vbp vbp vdd vdd sky130_fd_pr__pfet_01v8 W=4 L=2 nf=1
XM12 vbn vbp vdd vdd sky130_fd_pr__pfet_01v8 W=4 L=2 nf=1
* NMOS pair: M10 diode (1x), M9 (Kx) degenerated by Rs
XM10 vbn vbn vss vss sky130_fd_pr__nfet_01v8 W={WB} L={LB} nf=1 m={MB}
XM9  vbp vbn rs  vss sky130_fd_pr__nfet_01v8 W={WB} L={LB} nf=1 m={MB*K}
XRS  rs  vss vss sky130_fd_pr__res_xhigh_po_0p35 L={RSL} mult=1
* start-up: MS1 weak pull-up (6 x 0.6/20 stack; 0.42/20 fails the continuous-model ss bin check), MS2 releases once vbn rises, MS3 kicks vbp low
XMS1a x   vss s1a vdd sky130_fd_pr__pfet_01v8 W=0.6 L=20 nf=1
XMS1b s1a vss s1b vdd sky130_fd_pr__pfet_01v8 W=0.6 L=20 nf=1
XMS1c s1b vss s1c vdd sky130_fd_pr__pfet_01v8 W=0.6 L=20 nf=1
XMS1d s1c vss s1d vdd sky130_fd_pr__pfet_01v8 W=0.6 L=20 nf=1
XMS1e s1d vss s1e vdd sky130_fd_pr__pfet_01v8 W=0.6 L=20 nf=1
XMS1f s1e vss vdd vdd sky130_fd_pr__pfet_01v8 W=0.6 L=20 nf=1
XMS2 x   vbn vss vss sky130_fd_pr__nfet_01v8 W=7 L=1 nf=1 m=2
XMS3 vbp x   vss vss sky130_fd_pr__nfet_01v8 W=0.42 L=2 nf=1
* VREF: one PMOS unit (0.5 uA) into an NMOS diode, decoupled by CREF
XMR1 vref vbp vdd vdd sky130_fd_pr__pfet_01v8 W=4 L=2 nf=1
XMR2 vref vref vss vss sky130_fd_pr__nfet_01v8 W={WB} L={LB} nf=1 m={3*MB}
CREF vref vss 2p
.ends bias
